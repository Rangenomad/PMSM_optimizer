# Ansys Electronics Desktop project, version 2023.2
materials:
  vacuum: permittivity=1
  aluminum: permeability=1.000021 conductivity=38000000
  copper: permeability=0.999991 conductivity=58000000
  N36Z_20: permeability=1.03 magnetic_coercivity{Magnitude=-920000A_per_meter DirComp1=1 DirComp2=0 DirComp3=0}
  M19_29G: core_loss_curve{50Hz (0, 0) (0.1, 0.03) (0.2, 0.07) (0.3, 0.13) (0.4, 0.22) (0.5, 0.31) (0.6, 0.43) (0.7, 0.54) (0.8, 0.68) (0.9, 0.83) (1, 1.01) (1.1, 1.2) (1.2, 1.42) (1.3, 1.7) (1.4, 2.12) (1.5, 2.47) (1.6, 2.8) (1.7, 3.05) (1.8, 3.25)} core_loss_curve{100Hz (0, 0) (0.1, 0.04) (0.2, 0.16) (0.3, 0.34) (0.4, 0.55) (0.5, 0.8) (0.6, 1.08) (0.7, 1.38) (0.8, 1.73) (0.9, 2.1) (1, 2.51) (1.1, 2.98) (1.2, 3.51) (1.3, 4.15) (1.4, 4.97) (1.5, 5.92)} core_loss_curve{200Hz (0, 0) (0.1, 0.09) (0.2, 0.37) (0.3, 0.79) (0.4, 1.31) (0.5, 1.91) (0.6, 2.61) (0.7, 3.39) (0.8, 4.26) (0.9, 5.23) (1, 6.3) (1.1, 7.51) (1.2, 8.88) (1.3, 10.5) (1.4, 12.5) (1.5, 14.9)} core_loss_curve{400Hz (0, 0) (0.1, 0.21) (0.2, 0.92) (0.3, 1.99) (0.4, 3.33) (0.5, 4.94) (0.6, 6.84) (0.7, 9) (0.8, 11.4) (0.9, 14.2) (1, 17.3) (1.1, 20.9) (1.2, 24.9) (1.3, 29.5) (1.4, 35.4) (1.5, 41.8)} core_loss_curve{1000Hz (0, 0) (0.1, 0.99) (0.2, 3.67) (0.3, 7.63) (0.4, 12.7) (0.5, 18.9) (0.6, 26.4) (0.7, 35.4) (0.8, 46) (0.9, 58.4) (1, 73) (1.1, 90.1)} permeability{HUnit=A_per_meter BUnit=tesla curve (0, 0) (22.28, 0.05) (25.46, 0.1) (31.83, 0.15) (47.74, 0.36) (63.66, 0.54) (79.57, 0.65) (159.15, 0.99) (318.3, 1.2) (477.46, 1.28) (636.61, 1.33) (795.77, 1.36) (1591.5, 1.44) (3183, 1.52) (4774.6, 1.58) (6366.1, 1.63) (7957.7, 1.67) (15915, 1.8) (31830, 1.9) (111407, 2) (190984, 2.1) (350138, 2.3) (509252, 2.5) (560177.2, 2.563994494) (1527756, 3.779889874)} core_loss_type="Electrical Steel" core_loss_kh=184.23367 core_loss_kc=0.38626059 core_loss_ke=0.27023142 mass_density=7872

design 1_Whole_motor (Maxwell 2D, Transient, XY geometry, model units mm)
options: ModelDepth=1meter
geometry:
  Stator [vacuum] = user_primitive(RMxprt/SlotCore, DiaGap=161.9mm, DiaYoke=269.24mm, Length=0mm, Skew=0deg, Slots=48, SlotType=2, Hs0=1.03mm, Hs01=0mm, Hs1=0mm, Hs2=29.5mm, Bs0=1.93mm, Bs1=5mm, Bs2=8mm, Rs=5mm, FilletType=0, HalfSlot=0, SegAngle=0deg, LenRegion=200mm, InfoCore=0)
  Rotor [vacuum] = user_primitive(RMxprt/IPMCore, DiaGap=160.4mm, DiaYoke=110.64mm, Length=0mm, Poles=8, PoleType=5, D1=157.44mm, O1=3mm, O2=7.28mm, B1=4.7mm, Rib=14mm, HRib=3mm, DminMag=4.5mm, ThickMag=6.48mm, WidthMag=32mm, LenRegion=200mm, InfoCore=0)
  Magnet [vacuum] = user_primitive(RMxprt/IPMCore, DiaGap=160.4mm, DiaYoke=110.64mm, Length=0mm, Poles=8, PoleType=5, D1=157.44mm, O1=3mm, O2=7.28mm, B1=4.7mm, Rib=14mm, HRib=3mm, DminMag=4.5mm, ThickMag=6.48mm, WidthMag=32mm, LenRegion=200mm, InfoCore=1)
  PhaseA [copper] = user_primitive(RMxprt/LapCoil, DiaGap=161.9mm, DiaYoke=269.24mm, Length=0mm, Skew=0deg, Slots=48, SlotType=2, Hs0=1.28mm, Hs1=0.1mm, Hs2=29.7mm, Bs0=2.11mm, Bs1=3.14mm, Bs2=5.65mm, Rs=2.5mm, FilletType=0, Layers=1, CoilPitch=5, EndExt=5mm, SpanExt=18mm, BendAngle=0deg, SegAngle=10deg, LenRegion=200mm, InfoCoil=1)
  PhaseA.rotate(axis=Z, angle=7.5deg)
  PhaseC, PhaseB [copper] = PhaseA.duplicate_around_axis(axis=Z, angle=15deg, total=3)
  PhaseC_1..PhaseC_7 [copper] = PhaseC.duplicate_around_axis(axis=Z, angle=45deg, total=8)
  PhaseB_1..PhaseB_7 [copper] = PhaseB.duplicate_around_axis(axis=Z, angle=45deg, total=8)
  PhaseA_1..PhaseA_7 [copper] = PhaseA.duplicate_around_axis(axis=Z, angle=45deg, total=8)

design 2_Partial_motor (Maxwell 2D, Transient, XY geometry, model units mm)
options: ModelDepth=1meter
geometry:
  Stator [M19_29G] = user_primitive(RMxprt/SlotCore, DiaGap=161.9mm, DiaYoke=269.24mm, Length=0mm, Skew=0deg, Slots=48, SlotType=2, Hs0=1.03mm, Hs01=0mm, Hs1=0mm, Hs2=29.5mm, Bs0=1.93mm, Bs1=5mm, Bs2=8mm, Rs=5mm, FilletType=0, HalfSlot=0, SegAngle=0deg, LenRegion=200mm, InfoCore=0)
  Rotor [M19_29G] = user_primitive(RMxprt/IPMCore, DiaGap=160.4mm, DiaYoke=110.64mm, Length=0mm, Poles=8, PoleType=5, D1=157.44mm, O1=3mm, O2=7.28mm, B1=4.7mm, Rib=14mm, HRib=3mm, DminMag=4.5mm, ThickMag=6.48mm, WidthMag=32mm, LenRegion=200mm, InfoCore=0)
  PM1 [N36Z_20, oriented by PM1_CS] = user_primitive(RMxprt/IPMCore, DiaGap=160.4mm, DiaYoke=110.64mm, Length=0mm, Poles=8, PoleType=5, D1=157.44mm, O1=3mm, O2=7.28mm, B1=4.7mm, Rib=14mm, HRib=3mm, DminMag=4.5mm, ThickMag=6.48mm, WidthMag=32mm, LenRegion=200mm, InfoCore=1)
  PhaseA1 [copper] = user_primitive(RMxprt/LapCoil, DiaGap=161.9mm, DiaYoke=269.24mm, Length=0mm, Skew=0deg, Slots=48, SlotType=2, Hs0=1.28mm, Hs1=0.1mm, Hs2=29.7mm, Bs0=2.11mm, Bs1=3.14mm, Bs2=5.65mm, Rs=2.5mm, FilletType=0, Layers=1, CoilPitch=5, EndExt=5mm, SpanExt=18mm, BendAngle=0deg, SegAngle=10deg, LenRegion=200mm, InfoCoil=1)
  PhaseA1.rotate(axis=Z, angle=7.5deg)
  PhaseC1, PhaseB1 [copper] = PhaseA1.duplicate_around_axis(axis=Z, angle=15deg, total=3)
  PhaseC2 [copper] = PhaseC1.duplicate_around_axis(axis=Z, angle=45deg, total=8)  # copies kept: 7
  PhaseB2 [copper] = PhaseB1.duplicate_around_axis(axis=Z, angle=45deg, total=8)  # copies kept: 7
  PhaseA2 [copper] = PhaseA1.duplicate_around_axis(axis=Z, angle=45deg, total=8)  # copies kept: 7
  [Stator, Rotor, PM1, PhaseA1, PhaseC1, PhaseB1, PhaseC2, PhaseB2, PhaseA2].split(plane=ZX, keep=PositiveOnly)
  [Stator, Rotor, PM1, PhaseA1, PhaseC1, PhaseB1, PhaseC2, PhaseB2, PhaseA2].rotate(axis=Z, angle=-45deg)
  [Stator, Rotor, PM1, PhaseA1, PhaseC1, PhaseB1, PhaseC2, PhaseB2, PhaseA2].split(plane=ZX, keep=NegativeOnly)
  [Stator, Rotor, PM1, PhaseA1, PhaseC1, PhaseB1, PhaseC2, PhaseB2, PhaseA2].rotate(axis=Z, angle=45deg)
  Region [vacuum] = polyline((0mm, 0mm, 0mm) (200mm, 0mm, 0mm))
  Region.sweep_around_axis(axis=Z, angle=45deg, segments=5)
  PM2 [N36Z_20, oriented by PM2_CS] = PM1.separate_bodies()
  coordinate_system PM1_CS = face of PM1: Origin=(64.799739, 41.119197, 0) FaceID=PM1.face(7 of 16) AxisPosn=(62.589074, 35.027944, 0) WhichAxis=X ZRotationAngle=0 XOffset=0 YOffset=0 FaceNormal(0, 0, -1)
  coordinate_system PM2_CS = face of PM2: Origin=(69.025655, 19.488662, 0) FaceID=PM1.face(16 of 16) AxisPosn=(74.895998, 16.744672, 0) WhichAxis=X ZRotationAngle=0 XOffset=0 YOffset=0 FaceNormal(0, 0, -1)
boundaries and excitations:
  Master1: Independent Edges=Region.edge(at (100, 0, 0))
  Slave1: Dependent Edges=Region.edge(at (70.7107, 70.7107, 0)) ReverseU Independent=Master1 SameAsMaster=false

design 3_Partial_motor_MS (Maxwell 2D, Magnetostatic, XY geometry, model units mm)
options: ModelDepth=1meter
geometry:
  Stator [M19_29G] = user_primitive(RMxprt/SlotCore, DiaGap=161.9mm, DiaYoke=269.24mm, Length=0mm, Skew=0deg, Slots=48, SlotType=2, Hs0=1.03mm, Hs01=0mm, Hs1=0mm, Hs2=29.5mm, Bs0=1.93mm, Bs1=5mm, Bs2=8mm, Rs=5mm, FilletType=0, HalfSlot=0, SegAngle=0deg, LenRegion=200mm, InfoCore=0)
  Rotor [M19_29G] = user_primitive(RMxprt/IPMCore, DiaGap=160.4mm, DiaYoke=110.64mm, Length=0mm, Poles=8, PoleType=5, D1=157.44mm, O1=3mm, O2=7.28mm, B1=4.7mm, Rib=14mm, HRib=3mm, DminMag=4.5mm, ThickMag=6.48mm, WidthMag=32mm, LenRegion=200mm, InfoCore=0)
  PM1 [N36Z_20, oriented by PM1_CS] = user_primitive(RMxprt/IPMCore, DiaGap=160.4mm, DiaYoke=110.64mm, Length=0mm, Poles=8, PoleType=5, D1=157.44mm, O1=3mm, O2=7.28mm, B1=4.7mm, Rib=14mm, HRib=3mm, DminMag=4.5mm, ThickMag=6.48mm, WidthMag=32mm, LenRegion=200mm, InfoCore=1)
  PhaseA1 [copper, non-model] = user_primitive(RMxprt/LapCoil, DiaGap=161.9mm, DiaYoke=269.24mm, Length=0mm, Skew=0deg, Slots=48, SlotType=2, Hs0=1.28mm, Hs1=0.1mm, Hs2=29.7mm, Bs0=2.11mm, Bs1=3.14mm, Bs2=5.65mm, Rs=2.5mm, FilletType=0, Layers=1, CoilPitch=5, EndExt=5mm, SpanExt=18mm, BendAngle=0deg, SegAngle=10deg, LenRegion=200mm, InfoCoil=1)
  PhaseA1.rotate(axis=Z, angle=7.5deg)
  PhaseC1, PhaseB1 [copper, non-model] = PhaseA1.duplicate_around_axis(axis=Z, angle=15deg, total=3)
  PhaseC2 [copper, non-model] = PhaseC1.duplicate_around_axis(axis=Z, angle=45deg, total=8)  # copies kept: 7
  PhaseB2 [copper, non-model] = PhaseB1.duplicate_around_axis(axis=Z, angle=45deg, total=8)  # copies kept: 7
  PhaseA2 [copper, non-model] = PhaseA1.duplicate_around_axis(axis=Z, angle=45deg, total=8)  # copies kept: 7
  [Stator, Rotor, PM1, PhaseA1, PhaseC1, PhaseB1, PhaseC2, PhaseB2, PhaseA2].split(plane=ZX, keep=PositiveOnly)
  [Stator, Rotor, PM1, PhaseA1, PhaseC1, PhaseB1, PhaseC2, PhaseB2, PhaseA2].rotate(axis=Z, angle=-45deg)
  [Stator, Rotor, PM1, PhaseA1, PhaseC1, PhaseB1, PhaseC2, PhaseB2, PhaseA2].split(plane=ZX, keep=NegativeOnly)
  [Stator, Rotor, PM1, PhaseA1, PhaseC1, PhaseB1, PhaseC2, PhaseB2, PhaseA2].rotate(axis=Z, angle=45deg)
  Region [vacuum] = polyline((0mm, 0mm, 0mm) (200mm, 0mm, 0mm))
  Region.sweep_around_axis(axis=Z, angle=45deg, segments=5)
  PM2 [N36Z_20, oriented by PM2_CS] = PM1.separate_bodies()
  coordinate_system PM1_CS = face of PM1: Origin=(64.799739, 41.119197, 0) FaceID=PM1.face(at (56.1743, 40.8028, 0)) AxisPosn=(62.589074, 35.027944, 0) WhichAxis=X ZRotationAngle=0 XOffset=0 YOffset=0 FaceNormal(0, 0, -1)
  coordinate_system PM2_CS = face of PM2: Origin=(69.025655, 19.488662, 0) FaceID=PM2.face(at (68.5732, 10.8693, 0)) AxisPosn=(74.895998, 16.744672, 0) WhichAxis=X ZRotationAngle=0 XOffset=0 YOffset=0 FaceNormal(0, 0, -1)
  airgap_arc [non-model] = polyline(z=0mm, xy in mm: (80.575, 0) (74.441593, 30.834718) (56.975129, 56.975129) (57.05642, 56.853468) (57.084965, 56.70996), AngularArc from point 0 over 3 centre=(0, 0, 0) angle=45deg plane=XY, AngularArc from point 2 over 3 centre=(56.70996mm, 56.70996mm, 0mm) angle=-45deg plane=XY)
boundaries and excitations:
  Master1: Independent Edges=Region.edge(at (100, 0, 0))
  Slave1: Dependent Edges=Region.edge(at (70.7107, 70.7107, 0)) ReverseU Independent=Master1 SameAsMaster=false
parameters:
  Torque1: Torque Coordinate_System=Global Is_Positive=true Objects=[PM1, PM2, Rotor]
mesh:
  Rotor: LengthBased RefineInside Objects=Rotor MaxLength=5mm
  Magnets: LengthBased RefineInside Objects=[PM1, PM2] MaxLength=3mm
  SA_Stator: SurfApproxBased Objects=Stator CurvedSurfaceApproxChoice=ManualSettings NormalDev=30deg AspectRatio=5
setups:
  Setup1: Magnetostatic MaximumPasses=10 MinimumPasses=2 MinimumConvergedPasses=1 PercentRefinement=15 PercentError=0.1 NonLinearResidual=0.0001
field plots:
  Mag_B1: B over Stator.face(at (95.9301, 47.8809, 0)) Rotor.face(at (59.6586, 28.5251, 0)) PM2.face(at (68.5732, 10.8693, 0)) PM1.face(at (56.1743, 40.8028, 0)) on Setup1 : LastAdaptive
  H_Vector1: H on Setup1 : LastAdaptive
  Mesh1: MeshPlots over Stator.face(at (95.9301, 47.8809, 0)) Rotor.face(at (59.6586, 28.5251, 0)) PM1.face(at (56.1743, 40.8028, 0)) Region.face PM2.face(at (68.5732, 10.8693, 0)) on Setup1 : LastAdaptive

design 4_Partial_motor_MS2 (Maxwell 2D, Magnetostatic, XY geometry, model units mm)
options: ModelDepth=1meter
geometry:
  Stator [M19_29G] = user_primitive(RMxprt/SlotCore, DiaGap=161.9mm, DiaYoke=269.24mm, Length=0mm, Skew=0deg, Slots=48, SlotType=2, Hs0=1.03mm, Hs01=0mm, Hs1=0mm, Hs2=29.5mm, Bs0=1.93mm, Bs1=5mm, Bs2=8mm, Rs=5mm, FilletType=0, HalfSlot=0, SegAngle=0deg, LenRegion=200mm, InfoCore=0)
  Rotor [M19_29G] = user_primitive(RMxprt/IPMCore, DiaGap=160.4mm, DiaYoke=110.64mm, Length=0mm, Poles=8, PoleType=5, D1=157.44mm, O1=3mm, O2=7.28mm, B1=4.7mm, Rib=14mm, HRib=3mm, DminMag=4.5mm, ThickMag=6.48mm, WidthMag=32mm, LenRegion=200mm, InfoCore=0)
  PM1 [N36Z_20, oriented by PM1_CS] = user_primitive(RMxprt/IPMCore, DiaGap=160.4mm, DiaYoke=110.64mm, Length=0mm, Poles=8, PoleType=5, D1=157.44mm, O1=3mm, O2=7.28mm, B1=4.7mm, Rib=14mm, HRib=3mm, DminMag=4.5mm, ThickMag=6.48mm, WidthMag=32mm, LenRegion=200mm, InfoCore=1)
  PhaseA1 [copper] = user_primitive(RMxprt/LapCoil, DiaGap=161.9mm, DiaYoke=269.24mm, Length=0mm, Skew=0deg, Slots=48, SlotType=2, Hs0=1.28mm, Hs1=0.1mm, Hs2=29.7mm, Bs0=2.11mm, Bs1=3.14mm, Bs2=5.65mm, Rs=2.5mm, FilletType=0, Layers=1, CoilPitch=5, EndExt=5mm, SpanExt=18mm, BendAngle=0deg, SegAngle=10deg, LenRegion=200mm, InfoCoil=1)
  PhaseA1.rotate(axis=Z, angle=7.5deg)
  PhaseC1, PhaseB1 [copper] = PhaseA1.duplicate_around_axis(axis=Z, angle=15deg, total=3)
  PhaseC2 [copper] = PhaseC1.duplicate_around_axis(axis=Z, angle=45deg, total=8)  # copies kept: 7
  PhaseB2 [copper] = PhaseB1.duplicate_around_axis(axis=Z, angle=45deg, total=8)  # copies kept: 7
  PhaseA2 [copper] = PhaseA1.duplicate_around_axis(axis=Z, angle=45deg, total=8)  # copies kept: 7
  [Stator, Rotor, PM1, PhaseA1, PhaseC1, PhaseB1, PhaseC2, PhaseB2, PhaseA2].split(plane=ZX, keep=PositiveOnly)
  [Stator, Rotor, PM1, PhaseA1, PhaseC1, PhaseB1, PhaseC2, PhaseB2, PhaseA2].rotate(axis=Z, angle=-45deg)
  [Stator, Rotor, PM1, PhaseA1, PhaseC1, PhaseB1, PhaseC2, PhaseB2, PhaseA2].split(plane=ZX, keep=NegativeOnly)
  [Stator, Rotor, PM1, PhaseA1, PhaseC1, PhaseB1, PhaseC2, PhaseB2, PhaseA2].rotate(axis=Z, angle=45deg)
  Region [vacuum] = polyline((0mm, 0mm, 0mm) (200mm, 0mm, 0mm))
  Region.sweep_around_axis(axis=Z, angle=45deg, segments=5)
  PM2 [N36Z_20, oriented by PM2_CS] = PM1.separate_bodies()
  coordinate_system PM1_CS = face of PM1: Origin=(64.799739, 41.119197, 0) FaceID=PM1.face(at (56.1743, 40.8028, 0)) AxisPosn=(62.589074, 35.027944, 0) WhichAxis=X ZRotationAngle=0 XOffset=0 YOffset=0 FaceNormal(0, 0, -1)
  coordinate_system PM2_CS = face of PM2: Origin=(69.025655, 19.488662, 0) FaceID=PM2.face(at (68.5732, 10.8693, 0)) AxisPosn=(74.895998, 16.744672, 0) WhichAxis=X ZRotationAngle=0 XOffset=0 YOffset=0 FaceNormal(0, 0, -1)
  airgap_arc [non-model] = polyline(z=0mm, xy in mm: (80.575, 0) (74.441593, 30.834718) (56.975129, 56.975129) (57.05642, 56.853468) (57.084965, 56.70996), AngularArc from point 0 over 3 centre=(0, 0, 0) angle=45deg plane=XY, AngularArc from point 2 over 3 centre=(56.70996mm, 56.70996mm, 0mm) angle=-45deg plane=XY)
boundaries and excitations:
  Master1: Independent Edges=Region.edge(at (100, 0, 0))
  Slave1: Dependent Edges=Region.edge(at (70.7107, 70.7107, 0)) ReverseU Independent=Master1 SameAsMaster=false
  PhaseA1: Current Objects=PhaseA1 Current=1500A IsPositive=true
  PhaseA2: Current Objects=PhaseA2 Current=1500A IsPositive=true
  PhaseB1: Current Objects=PhaseB1 Current=-750A IsPositive=true
  PhaseB2: Current Objects=PhaseB2 Current=-750A IsPositive=true
  PhaseC1: Current Objects=PhaseC1 Current=-750A IsPositive=false
  PhaseC2: Current Objects=PhaseC2 Current=-750A IsPositive=false
parameters:
  Torque1: Torque Coordinate_System=Global Is_Positive=true Objects=[PM1, PM2, Rotor]
  Matrix1: Matrix PhaseA1, PhaseA2, PhaseB1, PhaseB2, PhaseC1, PhaseC2: NumberOfTurns=9; group PhaseA = PhaseA1, PhaseA2 (1 parallel); group PhaseB = PhaseB1, PhaseB2 (1 parallel); group PhaseC = PhaseC1, PhaseC2 (1 parallel)
mesh:
  Rotor: LengthBased RefineInside Objects=Rotor MaxLength=5mm
  Magnets: LengthBased RefineInside Objects=[PM1, PM2] MaxLength=3mm
  SA_Stator: SurfApproxBased Objects=Stator CurvedSurfaceApproxChoice=ManualSettings NormalDev=30deg AspectRatio=5
setups:
  Setup1: Magnetostatic MaximumPasses=10 MinimumPasses=2 MinimumConvergedPasses=1 PercentRefinement=15 PercentError=0.1 NonLinearResidual=0.0001
field plots:
  Mag_B1: B over Stator.face(at (95.9301, 47.8809, 0)) Rotor.face(at (59.6586, 28.5251, 0)) PM2.face(at (68.5732, 10.8693, 0)) PM1.face(at (56.1743, 40.8028, 0)) on Setup1 : LastAdaptive
  H_Vector1: H on Setup1 : LastAdaptive
  H_Vector2: H over a plane on Setup1 : LastAdaptive
  Mag_B2: B over Region.face on Setup1 : LastAdaptive

design 5_Partial_motor_TR (Maxwell 2D, Transient, XY geometry, model units mm)
options: ModelDepth=83.82mm
variables:
  Poles = 8
  PolePairs = Poles/2
  Speed_rpm = 2000rpm
  Omega = 360*speed_rpm*PolePairs/60
  Omega_rad = Omega*pi/180
  Thet_deg = -15
  Thet = thet_deg*pi/180
  Imax = 100A
geometry:
  Stator [M19_29G] = user_primitive(RMxprt/SlotCore, DiaGap=161.9mm, DiaYoke=269.24mm, Length=0mm, Skew=0deg, Slots=48, SlotType=2, Hs0=1.03mm, Hs01=0mm, Hs1=0mm, Hs2=29.5mm, Bs0=1.93mm, Bs1=5mm, Bs2=8mm, Rs=5mm, FilletType=0, HalfSlot=0, SegAngle=0deg, LenRegion=200mm, InfoCore=0)
  Rotor [M19_29G] = user_primitive(RMxprt/IPMCore, DiaGap=160.4mm, DiaYoke=110.64mm, Length=0mm, Poles=8, PoleType=5, D1=157.44mm, O1=3mm, O2=7.28mm, B1=4.7mm, Rib=14mm, HRib=3mm, DminMag=4.5mm, ThickMag=6.48mm, WidthMag=32mm, LenRegion=200mm, InfoCore=0)
  PM1 [N36Z_20, oriented by PM1_CS] = user_primitive(RMxprt/IPMCore, DiaGap=160.4mm, DiaYoke=110.64mm, Length=0mm, Poles=8, PoleType=5, D1=157.44mm, O1=3mm, O2=7.28mm, B1=4.7mm, Rib=14mm, HRib=3mm, DminMag=4.5mm, ThickMag=6.48mm, WidthMag=32mm, LenRegion=200mm, InfoCore=1)
  PhaseA1 [copper] = user_primitive(RMxprt/LapCoil, DiaGap=161.9mm, DiaYoke=269.24mm, Length=0mm, Skew=0deg, Slots=48, SlotType=2, Hs0=1.28mm, Hs1=0.1mm, Hs2=29.7mm, Bs0=2.11mm, Bs1=3.14mm, Bs2=5.65mm, Rs=2.5mm, FilletType=0, Layers=1, CoilPitch=5, EndExt=5mm, SpanExt=18mm, BendAngle=0deg, SegAngle=10deg, LenRegion=200mm, InfoCoil=1)
  PhaseA1.rotate(axis=Z, angle=7.5deg)
  PhaseC1, PhaseB1 [copper] = PhaseA1.duplicate_around_axis(axis=Z, angle=15deg, total=3)
  PhaseC2 [copper] = PhaseC1.duplicate_around_axis(axis=Z, angle=45deg, total=8)  # copies kept: 7
  PhaseB2 [copper] = PhaseB1.duplicate_around_axis(axis=Z, angle=45deg, total=8)  # copies kept: 7
  PhaseA2 [copper] = PhaseA1.duplicate_around_axis(axis=Z, angle=45deg, total=8)  # copies kept: 7
  [Stator, Rotor, PM1, PhaseA1, PhaseC1, PhaseB1, PhaseC2, PhaseB2, PhaseA2].split(plane=ZX, keep=PositiveOnly)
  [Stator, Rotor, PM1, PhaseA1, PhaseC1, PhaseB1, PhaseC2, PhaseB2, PhaseA2].rotate(axis=Z, angle=-45deg)
  [Stator, Rotor, PM1, PhaseA1, PhaseC1, PhaseB1, PhaseC2, PhaseB2, PhaseA2].split(plane=ZX, keep=NegativeOnly)
  [Stator, Rotor, PM1, PhaseA1, PhaseC1, PhaseB1, PhaseC2, PhaseB2, PhaseA2].rotate(axis=Z, angle=45deg)
  Region [vacuum] = polyline((0mm, 0mm, 0mm) (200mm, 0mm, 0mm))
  Region.sweep_around_axis(axis=Z, angle=45deg, segments=5)
  PM2 [N36Z_20, oriented by PM2_CS] = PM1.separate_bodies()
  coordinate_system PM1_CS = face of PM1: Origin=(64.799739, 41.119197, 0) FaceID=PM1.face(at (56.1743, 40.8028, 0)) AxisPosn=(62.589074, 35.027944, 0) WhichAxis=X ZRotationAngle=0 XOffset=0 YOffset=0 FaceNormal(0, 0, -1)
  coordinate_system PM2_CS = face of PM2: Origin=(69.025655, 19.488662, 0) FaceID=PM2.face(at (68.5732, 10.8693, 0)) AxisPosn=(74.895998, 16.744672, 0) WhichAxis=X ZRotationAngle=0 XOffset=0 YOffset=0 FaceNormal(0, 0, -1)
  Band [vacuum] = polyline((0mm, 0mm, 0mm) (80.575mm, 0mm, 0mm))
  Band.sweep_around_axis(axis=Z, angle=45deg)
  Band_in [vacuum] = polyline((0mm, 0mm, 0mm) (80.4mm, 0mm, 0mm))
  Band_in.sweep_around_axis(axis=Z, angle=45deg)
  Rotor2 [M19_29G] = polyline((78.72mm, 0mm, 0mm) (80.2mm, 0mm, 0mm))
  Rotor2.sweep_around_axis(axis=Z, angle=45deg)
  Rotor3 [M19_29G] = polyline((78.72mm, 0mm, 0mm) (79.46mm, 0mm, 0mm))
  Rotor3.sweep_around_axis(axis=Z, angle=45deg)
motion:
  MotionSetup1: Band Move_Type=Rotate Coordinate_System=Global Axis=Z Is_Positive=true InitPos=30deg Angular_Velocity=Speed_rpm Objects=Band
  Moving1: Moving Objects=[Rotor, PM1, PM2, Band_in, Rotor2, Rotor3]
boundaries and excitations:
  Master1: Independent Edges=Region.edge(at (100, 0, 0))
  Slave1: Dependent Edges=Region.edge(at (70.7107, 70.7107, 0)) ReverseU Independent=Master1 SameAsMaster=false
  VectorPotential1: Vector Potential Edges=Region.edge(at (161.803, 117.557, 0), at (146.986, 135.856, 0), at (178.201, 90.7981, 0), at (190.211, 61.8034, 0), at (197.538, 31.2869, 0), at (200, 7.87017, 0)) Value=0
  PhaseA1: Coil Objects=PhaseA1 Conductor_number=9 Winding=Phase_A PolarityType=Positive
  PhaseA2: Coil Objects=PhaseA2 Conductor_number=9 Winding=Phase_A PolarityType=Positive
  PhaseB1: Coil Objects=PhaseB1 Conductor_number=9 Winding=Phase_B PolarityType=Positive
  PhaseB2: Coil Objects=PhaseB2 Conductor_number=9 Winding=Phase_B PolarityType=Positive
  PhaseC1: Coil Objects=PhaseC1 Conductor_number=9 Winding=Phase_C PolarityType=Negative
  PhaseC2: Coil Objects=PhaseC2 Conductor_number=9 Winding=Phase_C PolarityType=Negative
  Phase_A: Winding Group Type=Current IsSolid=false Current=Imax*sin(Omega_rad*time+thet) ParallelBranchesNum=1
  Phase_B: Winding Group Type=Current IsSolid=false Current=Imax*sin(Omega_rad*time-2*pi/3+thet) ParallelBranchesNum=1
  Phase_C: Winding Group Type=Current IsSolid=false Current=Imax*sin(Omega_rad*time+2*pi/3+thet) ParallelBranchesNum=1
  core loss on: Stator, Rotor, Rotor2, Rotor3
mesh:
  Coils: LengthBased RefineInside Objects=[PhaseC2, PhaseA1, PhaseA2, PhaseB1, PhaseB2, PhaseC1] MaxLength=4mm
  Magnets: LengthBased RefineInside Objects=[PM1, PM2] MaxLength=3mm
  Rotor: LengthBased RefineInside Objects=Rotor MaxLength=4mm
  Stator: LengthBased RefineInside Objects=Stator MaxLength=4mm
  CylindricalGap1: CylindricalGap Objects=Band Objects=Band
setups:
  Setup1: Transient NonlinearSolverResidual=1e-06 StopTime=0.0225s TimeStep=0.00015s SaveFieldsType=Custom SweepRanges{0s to 20ms step 250us} NumberSolveSteps=1 RangeStart=0s RangeEnd=0.1s InitialTimeStep=0.002s MinTimeStep=0.001s MaxTimeStep=0.003s TimeStepErrTolerance=0.0001
optimetrics:
  ParametricSetup1: Parametric InterpolationPoints=0 Sim._Setups=[Setup1]
    sweep Thet_deg: LIN 0 60 15
field plots:
  Mag_B1: B over Rotor.face(at (59.6586, 28.5251, 0)) Rotor2.face Rotor3.face Stator.face(at (95.9301, 47.8809, 0)) PM1.face(at (56.1743, 40.8028, 0)) PM2.face(at (68.5732, 10.8693, 0)) on Setup1 : Transient at Time=-1
reports:
  Torque: Moving1.LoadTorque, Moving1.Torque vs Time on Setup1 : Transient [Poles=all Speed_rpm=all Thet_deg=all Imax=all]
  XY Plot 1: FluxLinkage(Phase_A), FluxLinkage(Phase_B), FluxLinkage(Phase_C) vs Time on Setup1 : Transient
  XY Plot 2: InducedVoltage(Phase_A), InducedVoltage(Phase_B), InducedVoltage(Phase_C) vs Time on Setup1 : Transient

design 6_Partial_motor_CT (Maxwell 2D, Transient, XY geometry, model units mm)
options: ModelDepth=83.82mm
variables:
  Poles = 8
  PolePairs = Poles/2
  Speed_rpm = 3000
  Omega = 360*speed_rpm*PolePairs/60
  Omega_rad = Omega*pi/180
  Thet_deg = 20
  Thet = thet_deg*pi/180
  Imax = 250A
geometry:
  Stator [M19_29G] = user_primitive(RMxprt/SlotCore, DiaGap=161.9mm, DiaYoke=269.24mm, Length=0mm, Skew=0deg, Slots=48, SlotType=2, Hs0=1.03mm, Hs01=0mm, Hs1=0mm, Hs2=29.5mm, Bs0=1.93mm, Bs1=5mm, Bs2=8mm, Rs=5mm, FilletType=0, HalfSlot=0, SegAngle=0deg, LenRegion=200mm, InfoCore=0)
  Rotor [M19_29G] = user_primitive(RMxprt/IPMCore, DiaGap=160.4mm, DiaYoke=110.64mm, Length=0mm, Poles=8, PoleType=5, D1=157.44mm, O1=3mm, O2=7.28mm, B1=4.7mm, Rib=14mm, HRib=3mm, DminMag=4.5mm, ThickMag=6.48mm, WidthMag=32mm, LenRegion=200mm, InfoCore=0)
  PM1 [N36Z_20, oriented by PM1_CS] = user_primitive(RMxprt/IPMCore, DiaGap=160.4mm, DiaYoke=110.64mm, Length=0mm, Poles=8, PoleType=5, D1=157.44mm, O1=3mm, O2=7.28mm, B1=4.7mm, Rib=14mm, HRib=3mm, DminMag=4.5mm, ThickMag=6.48mm, WidthMag=32mm, LenRegion=200mm, InfoCore=1)
  [Stator, Rotor, PM1].split(plane=ZX, keep=PositiveOnly)
  [Stator, Rotor, PM1].rotate(axis=Z, angle=-45deg)
  [Stator, Rotor, PM1].split(plane=ZX, keep=NegativeOnly)
  [Stator, Rotor, PM1].rotate(axis=Z, angle=45deg)
  Region [vacuum] = polyline((0mm, 0mm, 0mm) (200mm, 0mm, 0mm))
  Region.sweep_around_axis(axis=Z, angle=45deg, segments=5)
  PM2 [N36Z_20, oriented by PM2_CS] = PM1.separate_bodies()
  coordinate_system PM1_CS = face of PM1: Origin=(64.799739, 41.119197, 0) FaceID=PM1.face(at (56.1743, 40.8028, 0)) AxisPosn=(62.589074, 35.027944, 0) WhichAxis=X ZRotationAngle=0 XOffset=0 YOffset=0 FaceNormal(0, 0, -1)
  coordinate_system PM2_CS = face of PM2: Origin=(69.025655, 19.488662, 0) FaceID=PM2.face(at (68.5732, 10.8693, 0)) AxisPosn=(74.895998, 16.744672, 0) WhichAxis=X ZRotationAngle=0 XOffset=0 YOffset=0 FaceNormal(0, 0, -1)
  Band [vacuum] = polyline((0mm, 0mm, 0mm) (80.575mm, 0mm, 0mm))
  Band.sweep_around_axis(axis=Z, angle=45deg)
  Band_in [vacuum] = polyline((0mm, 0mm, 0mm) (80.4mm, 0mm, 0mm))
  Band_in.sweep_around_axis(axis=Z, angle=45deg)
  Rotor2 [M19_29G] = polyline((78.72mm, 0mm, 0mm) (80.2mm, 0mm, 0mm))
  Rotor2.sweep_around_axis(axis=Z, angle=45deg)
  Rotor3 [M19_29G] = polyline((78.72mm, 0mm, 0mm) (79.46mm, 0mm, 0mm))
  Rotor3.sweep_around_axis(axis=Z, angle=45deg)
  Band_out [vacuum] = polyline((0mm, 0mm, 0mm) (80.75mm, 0mm, 0mm))
  Band_out.sweep_around_axis(axis=Z, angle=45deg)
motion:
  MotionSetup1: Band Move_Type=Rotate Coordinate_System=Global Axis=Z Is_Positive=true InitPos=0deg Angular_Velocity=1deg_per_sec Objects=Band
  Moving1: Moving Objects=[Rotor, PM1, PM2, Band_in, Rotor2, Rotor3]
boundaries and excitations:
  Master1: Independent Edges=Region.edge(at (100, 0, 0))
  Slave1: Dependent Edges=Region.edge(at (70.7107, 70.7107, 0)) ReverseU Independent=Master1 SameAsMaster=false
  core loss on: Stator, Rotor, Rotor2, Rotor3
mesh:
  Magnets: LengthBased RefineInside Objects=[PM1, PM2] MaxLength=3mm
  Rotor: LengthBased RefineInside Objects=Rotor MaxLength=3mm
  Stator: LengthBased RefineInside Objects=Stator MaxLength=3mm
  SA_stator_rotor: SurfApproxBased Objects=[Rotor, Rotor2, Rotor3, Stator] CurvedSurfaceApproxChoice=ManualSettings NormalDev=1deg
  CylindricalGap1: CylindricalGap Objects=Band Objects=Band
setups:
  Setup1: Transient NonlinearSolverResidual=0.0001 StopTime=15s TimeStep=0.125s InitialTimeStep=0.002s MinTimeStep=0.001s MaxTimeStep=0.003s TimeStepErrTolerance=0.0001
optimetrics:
  ParametricSetup1: Parametric InterpolationPoints=0 Sim._Setups=[Setup1]
    sweep Thet_deg: LIN 0 60 15
field plots:
  Mag_B1: B over Rotor.face(at (59.6586, 28.5251, 0)) Rotor2.face Rotor3.face Stator.face(at (95.9301, 47.8809, 0)) PM1.face(at (56.1743, 40.8028, 0)) PM2.face(at (68.5732, 10.8693, 0)) on Setup1 : Transient at Time=-1
reports:
  Torque: Moving1.LoadTorque, Moving1.Torque vs Time on Setup1 : Transient [Poles=all Speed_rpm=all Thet_deg=all Imax=all]
  XY Plot 1: FluxLinkage(Phase_A), FluxLinkage(Phase_B), FluxLinkage(Phase_C) vs Time on Setup1 : Transient
  XY Plot 2: InducedVoltage(Phase_A), InducedVoltage(Phase_B), InducedVoltage(Phase_C) vs Time on Setup1 : Transient
  XY Plot 3: Moving1.Torque vs Time on Setup1 : Transient [Thet_deg=all]
